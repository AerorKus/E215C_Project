ADE simulation setup
Test ECE215CProject_LNA_1: ECE215CProject/LNA/schematic, simulator spectre
  Models: /w/class.1/ee/ee209b/ee209bta/TSMC180PDK/PDK/tsmc18/../models/spectre/cr018gpii_v1d0.scs[tt_rfres_sa, tt_rfmvar, tt_rtmom, tt_disres, tt, tt_rfesd, tt_mim, tt_fmom, tt_rfres_rpo, tt_m, tt_rfmim, tt_res, tt_bip, tt_bip3, tt_dio3, tt_3v, tt_na, tt_dio, tt_dio_m, tt_rfind, tt_dio_3m, tt_bbmvar, tt_rfres_hri, tt_3vna, tt_dio_dnw, tt_3m, tt_rfjvar, tt_rfmos, tt_rfsbd, tt_rfmvar_33, tt_rfmos33, tt_rffmom, stat_noise]
  Variables: C = 10p; L = 115n; Ld = 15n; Ls = 700p; Viip3 = -30; Pin = -30; R = 100k
  Temperature: 27
  Analysis hb: sweep variable fundfreqs=("(10M)") maxharms=("5") tstab=auto errpreset=moderate
  Signals: /net4, /net6
Run mode: Single Run, Sweeps and Corners
Setup values for test ECE215CProject_LNA_1: Viip3 = 1m; Pin = -40
