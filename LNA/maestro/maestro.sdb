ADE simulation setup
Run mode: Single Run, Sweeps and Corners
Tests:
  ECE215CProject_LNA_1: ECE215CProject/LNA/schematic, simulator spectre
