ADE simulation setup
Run mode: Single Run, Sweeps and Corners
Tests:
  ECE215CProject_LNA_1: ECE215CProject/LNA/schematic, simulator spectre
    Variables: C = 10p; L = 115n; Ld = 15n; Ls = 700p; Viip3 = 1m; Pin = -40
